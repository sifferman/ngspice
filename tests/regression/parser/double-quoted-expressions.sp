* double-quoted-expressions.sp
.model diode_double_quoted d is="1e-14*10**2"
i_double_quoted 0 double_quoted 1m
d_double_quoted double_quoted 0 diode_double_quoted
.end

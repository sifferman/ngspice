* pre_osdi: modules of the same name without version load once

.model module_card dummy_mos
v_module_card module_card 0 1
n_module_card module_card 0 0 0 module_card

.control
* the modules of dummy_modules_tenfold.osdi are ignored, as is the second load
pre_osdi dummy_modules.osdi dummy_modules_tenfold.osdi
pre_osdi dummy_modules.osdi dummy_missing.osdi
op
print i(v_module_card)
.endc

.end
